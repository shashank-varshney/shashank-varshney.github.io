ADE simulation setup
Run mode: Single Run, Sweeps and Corners
Tests:
  ATD:delay:1: ATD/delay/schematic, simulator spectre
Corners:
  model folders: /afs/vlsi.iitd.ernet.in/service/tools/public/asiclib/umcoa/L90/process/UMK90FDK_OA/Models/Spectre
  C0: temperature=-40 27 85; L90_SPHVT10_V111.lib.scs[ff fnsp snfp ss tt], L90SP_NCAP10_V112.lib.scs, rnnpo_rf_V011.lib.scs
